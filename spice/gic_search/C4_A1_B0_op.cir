* op
.include ../OPAx197.LIB
VCC vcc 0 12
VEE vee 0 -12
C1 a 0 10n
LG a xg 1.176m
RG xg 0 4.555
R1 a g2 2k
R2 g2 g3 2k
R3 g3 g4 2k
C4 g4 g5 1n
R5 g5 0 3333.3
XA g3 a vcc vee g2 OPAx197
XB g3 g5 vcc vee g4 OPAx197
.control
op
print v(a) v(g2) v(g4)
.endc
.end
