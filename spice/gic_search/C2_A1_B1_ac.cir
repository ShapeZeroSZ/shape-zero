* ac
.include ../OPAx197.LIB
VCC vcc 0 12
VEE vee 0 -12
R1 a g2 2k
C2 g2 g3 1n
R3 g3 g4 2k
R4 g4 g5 2k
R5 g5 0 3333.3
XA g3 a vcc vee g2 OPAx197
XB g5 g3 vcc vee g4 OPAx197
IIN 0 a dc 0 ac 1
.control
ac lin 3 50k 70k
print frequency v(a)
.endc
.end
