* 32-node LC-gyrator ring (shape_zero realisation-gyroscopic branch)
.include OPAx197.LIB
VCC vcc 0 12
VEE vee 0 -12
* ---- cells (design choices ours) ----
.subckt NODE a vcc vee params: R5=3333.3
C1 a 0 10n
LG a xg 0.001176
RG xg 0 4.55463
RG1 a g2 2k
RG2 g2 g3 2k
RG3 g3 g4 2k
CG4 g4 g5 1n
RG5 g5 0 {R5}
XGA a g3 vcc vee g2 OPAx197
XGB g5 g3 vcc vee g4 OPAx197
.ends NODE
.subckt BOND a b vcc vee params: Rset=2983.28
LC a yc 0.004
RC yc b 15.4919
CP a b 1e-11
* diagnostic variant: ideal VCCS
GB 0 b a 0 {1/Rset}
GA a 0 b 0 {1/Rset}
.ends BOND

XN0 n0 vcc vee NODE params: R5=3340.91
XN1 n1 vcc vee NODE params: R5=3340.91
XN2 n2 vcc vee NODE params: R5=3340.91
XN3 n3 vcc vee NODE params: R5=3340.91
XN4 n4 vcc vee NODE params: R5=3340.91
XN5 n5 vcc vee NODE params: R5=3340.91
XN6 n6 vcc vee NODE params: R5=3340.91
XN7 n7 vcc vee NODE params: R5=3340.91
XN8 n8 vcc vee NODE params: R5=3340.91
XN9 n9 vcc vee NODE params: R5=3340.91
XN10 n10 vcc vee NODE params: R5=3340.91
XN11 n11 vcc vee NODE params: R5=3340.91
XN12 n12 vcc vee NODE params: R5=3340.91
XN13 n13 vcc vee NODE params: R5=3340.91
XN14 n14 vcc vee NODE params: R5=3340.91
XN15 n15 vcc vee NODE params: R5=3340.91
XN16 n16 vcc vee NODE params: R5=3340.91
XN17 n17 vcc vee NODE params: R5=3340.91
XN18 n18 vcc vee NODE params: R5=3340.91
XN19 n19 vcc vee NODE params: R5=3340.91
XN20 n20 vcc vee NODE params: R5=3340.91
XN21 n21 vcc vee NODE params: R5=3340.91
XN22 n22 vcc vee NODE params: R5=3340.91
XN23 n23 vcc vee NODE params: R5=3340.91
XN24 n24 vcc vee NODE params: R5=3340.91
XN25 n25 vcc vee NODE params: R5=3340.91
XN26 n26 vcc vee NODE params: R5=3340.91
XN27 n27 vcc vee NODE params: R5=3340.91
XN28 n28 vcc vee NODE params: R5=3340.91
XN29 n29 vcc vee NODE params: R5=3340.91
XN30 n30 vcc vee NODE params: R5=3340.91
XN31 n31 vcc vee NODE params: R5=3340.91
LC0 n0 yc0 0.004
RC0 yc0 n1 15.4919
CP0 n0 n1 1e-11
LC1 n1 yc1 0.004
RC1 yc1 n2 15.4919
CP1 n1 n2 1e-11
LC2 n2 yc2 0.004
RC2 yc2 n3 15.4919
CP2 n2 n3 1e-11
LC3 n3 yc3 0.004
RC3 yc3 n4 15.4919
CP3 n3 n4 1e-11
LC4 n4 yc4 0.004
RC4 yc4 n5 15.4919
CP4 n4 n5 1e-11
LC5 n5 yc5 0.004
RC5 yc5 n6 15.4919
CP5 n5 n6 1e-11
LC6 n6 yc6 0.004
RC6 yc6 n7 15.4919
CP6 n6 n7 1e-11
LC7 n7 yc7 0.004
RC7 yc7 n8 15.4919
CP7 n7 n8 1e-11
LC8 n8 yc8 0.004
RC8 yc8 n9 15.4919
CP8 n8 n9 1e-11
LC9 n9 yc9 0.004
RC9 yc9 n10 15.4919
CP9 n9 n10 1e-11
LC10 n10 yc10 0.004
RC10 yc10 n11 15.4919
CP10 n10 n11 1e-11
LC11 n11 yc11 0.004
RC11 yc11 n12 15.4919
CP11 n11 n12 1e-11
LC12 n12 yc12 0.004
RC12 yc12 n13 15.4919
CP12 n12 n13 1e-11
LC13 n13 yc13 0.004
RC13 yc13 n14 15.4919
CP13 n13 n14 1e-11
LC14 n14 yc14 0.004
RC14 yc14 n15 15.4919
CP14 n14 n15 1e-11
LC15 n15 yc15 0.004
RC15 yc15 n16 15.4919
CP15 n15 n16 1e-11
LC16 n16 yc16 0.004
RC16 yc16 n17 15.4919
CP16 n16 n17 1e-11
LC17 n17 yc17 0.004
RC17 yc17 n18 15.4919
CP17 n17 n18 1e-11
LC18 n18 yc18 0.004
RC18 yc18 n19 15.4919
CP18 n18 n19 1e-11
LC19 n19 yc19 0.004
RC19 yc19 n20 15.4919
CP19 n19 n20 1e-11
LC20 n20 yc20 0.004
RC20 yc20 n21 15.4919
CP20 n20 n21 1e-11
LC21 n21 yc21 0.004
RC21 yc21 n22 15.4919
CP21 n21 n22 1e-11
LC22 n22 yc22 0.004
RC22 yc22 n23 15.4919
CP22 n22 n23 1e-11
LC23 n23 yc23 0.004
RC23 yc23 n24 15.4919
CP23 n23 n24 1e-11
LC24 n24 yc24 0.004
RC24 yc24 n25 15.4919
CP24 n24 n25 1e-11
LC25 n25 yc25 0.004
RC25 yc25 n26 15.4919
CP25 n25 n26 1e-11
LC26 n26 yc26 0.004
RC26 yc26 n27 15.4919
CP26 n26 n27 1e-11
LC27 n27 yc27 0.004
RC27 yc27 n28 15.4919
CP27 n27 n28 1e-11
LC28 n28 yc28 0.004
RC28 yc28 n29 15.4919
CP28 n28 n29 1e-11
LC29 n29 yc29 0.004
RC29 yc29 n30 15.4919
CP29 n29 n30 1e-11
LC30 n30 yc30 0.004
RC30 yc30 n31 15.4919
CP30 n30 n31 1e-11
LC31 n31 yc31 0.004
RC31 yc31 n0 15.4919
CP31 n31 n0 1e-11
IDRV 0 n0 dc 0 ac 1
.control
set wr_singlescale
set wr_vecnames
ac lin 1081 48000 75000
wrdata /home/user/rg/spice/out/d_B_idealVCCS_band.txt v(n0) v(n1) v(n2) v(n3) v(n4) v(n5) v(n6) v(n7) v(n8) v(n9) v(n10) v(n11) v(n12) v(n13) v(n14) v(n15) v(n16) v(n17) v(n18) v(n19) v(n20) v(n21) v(n22) v(n23) v(n24) v(n25) v(n26) v(n27) v(n28) v(n29) v(n30) v(n31)
.endc
.end
